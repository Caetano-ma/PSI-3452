* cfg 1: M1 W=1 L=4 | M2 W=10 L=1
.lib "C:/Users/caean/EDA/pdk/sky130A/libs.tech/ngspice/sky130.lib.spice" tt
VBAT vbat 0 3.7
XM1 vbat 0    vref 0 sky130_fd_pr__nfet_05v0_nvt   W=1 L=4 nf=1
XM2 vref vref 0    0 sky130_fd_pr__nfet_g5v0d10v5  W=10 L=1 nf=1
.control
foreach t -20 0 27 60 85
set temp = $t
op
print v(vref)
end
quit
.endc
.end
