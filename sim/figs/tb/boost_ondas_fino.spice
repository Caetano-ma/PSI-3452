* Boost em malha completa: celula FV -> L externo -> boost -> bateria
.lib "C:/Users/caean/EDA/pdk/sky130A/libs.tech/ngspice/sky130.lib.spice" tt
.include "../../blocos/celula_fv.spice"
.include "../../blocos/oscilador.spice"
.include "../../blocos/boost.spice"
.param VB=3.7 IPH=50u
* celula + capacitor de entrada (externo)
Xcel vin_dc 0 celula_fv Iph={IPH}
Vmi vin_dc vin 0
Cin vin 0 100n IC=0.599
* indutor externo 220 uH (DCR 5 ohm)
L1 vin lx 220u IC=0
RL lx lbst 5
* bateria (fonte ideal) com medidor de corrente
Vbat vstor_m 0 {VB}
Vmo vstor vstor_m 0
Cout vstor 0 1u
* oscilador alimentado por VDD ideal (o Cold-Start ja foi validado)
VDD vdd 0 2.2
Xosc vdd clk oscilador
Xbst lbst clk vstor boost
.control
set wr_singlescale
set wr_vecnames
save all @d.xbst.dr[id]
tran 2n 0.6m 0.5m 2n uic
meas tran vin_med avg v(vin)    from=0.5m to=0.6m
let pin_t  = v(vin_dc)*i(Vmi)
let pout_t = v(vstor)*i(Vmo)
meas tran pin    avg pin_t      from=0.5m to=0.6m
meas tran pout   avg pout_t     from=0.5m to=0.6m
meas tran ipk    max i(L1)      from=0.5m to=0.6m
meas tran iosc   avg i(VDD)     from=0.5m to=0.6m
let posc = -iosc*2.2
let eta_boost = pout/pin*100
let eta_total = (pout-posc)/pin*100
print pout posc eta_boost eta_total
wrdata ../dados/boost_ondas.txt v(clk) v(lbst) i(L1) @d.xbst.dr[id] v(vin) v(vstor)
quit
.endc
.end
