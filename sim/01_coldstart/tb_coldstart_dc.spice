* Cold-Start: regulacao de linha e carga (estado 0-0, alimentado por VBAT)
.lib "C:/Users/caean/EDA/pdk/sky130A/libs.tech/ngspice/sky130.lib.spice" tt
.include "../blocos/coldstart.spice"
VBAT vbat 0 3.7
VTRG trigger 0 0
* estado 0-0: CTRL_LOW e CTRL_HIGH inativos (= VBAT)
BL ctrl_low 0 V = v(vbat)
BH ctrl_high 0 V = v(vbat)
X1 vbat trigger ctrl_low ctrl_high vdd coldstart
ILOAD vdd 0 2u
.control
dc VBAT 2.5 4.5 0.1
print v(vdd) i(VBAT)
dc ILOAD 0.1u 20u 1u
print v(vdd)
foreach t 0 27 60
set temp = $t
op
print v(vdd)
end
quit
.endc
.end
