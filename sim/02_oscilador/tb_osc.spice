* Oscilador: frequencia, largura do pulso, consumo; carga = gate da chave do boost
.lib "C:/Users/caean/EDA/pdk/sky130A/libs.tech/ngspice/sky130.lib.spice" tt
.include "../blocos/oscilador.spice"
VDD vdd 0 2.2
X1 vdd clk oscilador Cr=1p Cd=0.2p
* carga: chave NMOS do boost (W=200u, L=0.5u)
XSW 0 clk 0 0 sky130_fd_pr__nfet_g5v0d10v5 W=20 L=0.5 nf=1 m=10
.ic v(x1.r1)=0 v(x1.r2)=2.2 v(x1.r3)=0 v(x1.r4)=2.2 v(x1.r5)=0
.control
tran 2n 200u uic
meas tran t1 when v(clk)=1.1 rise=5
meas tran t2 when v(clk)=1.1 rise=6
meas tran tf when v(clk)=1.1 fall=5
let per = t2 - t1
let freq = 1/per
let ton = tf - t1
print freq ton
meas tran ivdd avg i(VDD) from=t1 to=t2
let pw = -ivdd*2.2
print pw
quit
.endc
.end
